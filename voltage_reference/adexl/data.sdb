ADE simulation setup
Run mode: Single Run, Sweeps and Corners
Tests:
  EESM_lib:voltage_reference:1: EESM_lib/voltage_reference/schematic, simulator spectre
